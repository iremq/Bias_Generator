** sch_path: /foss/designs/ihp_INI_project/xschem_bias_gen/test_bench/SelMUX_alone_dc_tb.sch
**.subckt SelMUX_alone_dc_tb
v_en BIASGEN_en_VS vssa 1.2
Vdd vdda vssa 1.2
Vss vssa GND 0
xinv[2] vdda en_VSB[2] en_VS[2] vssa inv
xinv[1] vdda en_VSB[1] en_VS[1] vssa inv
xinv[0] vdda en_VSB[0] en_VS[0] vssa inv
V0 en_VS[0] vssa 1.2
V1 en_VS[1] vssa 1.2
V2 en_VS[2] vssa 1.2
x1 ref_VUN[7] ref_VUN[6] ref_VUN[5] ref_VUN[4] ref_VUN[3] ref_VUN[2] ref_VUN[1] ref_VUN[0] vssa en_VS[2] en_VS[1] en_VS[0]
+ en_VSB[2] en_VSB[1] en_VSB[0] out_Mux SelMUX
Vdd1 ref_VUN[0] vssa 0.125
Vdd2 ref_VUN[1] vssa 0.20
Vdd3 ref_VUN[2] vssa 0.29
Vdd4 ref_VUN[3] vssa 0.37
Vdd5 ref_VUN[4] vssa 0.45
Vdd6 ref_VUN[5] vssa 0.53648
Vdd7 ref_VUN[6] vssa 0.64832
Vdd8 ref_VUN[7] vssa 0.876
**** begin user architecture code

.lib cornerMOShv.lib mos_tt

.param temp=27

.options abstol=1e-13
.options gmin=1e-13
.control
save all
let digitalCommand = vector(8)
let BIAS_UN = vector(8)

let code = 0

while code < 8
    * Set the 8 bits
    alter V0 = 1.2*(code % 2)
    alter V1 = 1.2*(floor(code/2) % 2)
    alter V2 = 1.2*(floor(code/4) % 2)
    op
    let digitalCommand[code] = code
    let BIAS_UN[code]   = i(v.x1.V_ref_u_5)
    let code = code + 1
    write SelMux_alone_cases/SelMux_alone_case_{$&code}.raw
end

    setplot const
    settype current BIAS_UN
    setscale digitalCommand
    plot BIAS_UN

    write SelMUC_alone_dc_tb.raw BIAS_UN

.endc

**** end user architecture code
**.ends

* expanding   symbol:  inv.sym # of pins=4
** sym_path: /foss/designs/ihp_INI_project/xschem_bias_gen/inv.sym
** sch_path: /foss/designs/ihp_INI_project/xschem_bias_gen/inv.sch
.subckt inv vdda out in vssa
*.ipin in
*.opin out
*.iopin vssa
*.iopin vdda
XM1 out in vdda vdda sg13_hv_pmos w=4u l=0.5u ng=1
XM2 out in vssa vssa sg13_hv_nmos w=4u l=0.5u ng=1
.ends

* expanding   symbol:  SelMUX.sym # of pins=5
** sym_path: /foss/designs/ihp_INI_project/xschem_bias_gen/SelMUX.sym
** sch_path: /foss/designs/ihp_INI_project/xschem_bias_gen/SelMUX.sch
.subckt SelMUX MASTER_bias_VN[7] MASTER_bias_VN[6] MASTER_bias_VN[5] MASTER_bias_VN[4] MASTER_bias_VN[3] MASTER_bias_VN[2]
+ MASTER_bias_VN[1] MASTER_bias_VN[0] vssa en_VS[2] en_VS[1] en_VS[0] en_VSB[2] en_VSB[1] en_VSB[0] MASTER_biasout_VN
*.ipin
*+ MASTER_bias_VN[7],MASTER_bias_VN[6],MASTER_bias_VN[5],MASTER_bias_VN[4],MASTER_bias_VN[3],MASTER_bias_VN[2],MASTER_bias_VN[1],MASTER_bias_VN[0]
*.opin MASTER_biasout_VN
*.ipin en_VS[2],en_VS[1],en_VS[0]
*.ipin en_VSB[2],en_VSB[1],en_VSB[0]
*.iopin vssa
XMUX_L0_0 net14 en_VS[0] net1 net1 sg13_hv_nmos w=0.45u l=11.25u ng=1
XMUX_L0_1 net13 en_VSB[0] net1 net1 sg13_hv_nmos w=0.45u l=11.25u ng=1
XMUX_L0_2 net12 en_VS[0] net2 net2 sg13_hv_nmos w=0.45u l=11.25u ng=1
XMUX_L0_3 net11 en_VSB[0] net2 net2 sg13_hv_nmos w=0.45u l=11.25u ng=1
XMUX_L0_4 net10 en_VS[0] net3 net3 sg13_hv_nmos w=0.45u l=11.25u ng=1
XMUX_L0_5 net9 en_VSB[0] net3 net15 sg13_hv_nmos w=0.45u l=11.25u ng=1
XMUX_L0_6 net8 en_VS[0] net4 net4 sg13_hv_nmos w=0.45u l=11.25u ng=1
XMUX_L0_7 net7 en_VSB[0] net4 net4 sg13_hv_nmos w=0.45u l=11.25u ng=1
XMUX_L1_A net1 en_VS[1] net5 net5 sg13_hv_nmos w=0.45u l=11.25u ng=1
XMUX_L1_B net2 en_VSB[1] net5 net5 sg13_hv_nmos w=0.45u l=11.25u ng=1
XMUX_L1_C net3 en_VS[1] net6 net6 sg13_hv_nmos w=0.45u l=11.25u ng=1
XMUX_L1_D net4 en_VSB[1] net6 net6 sg13_hv_nmos w=0.45u l=11.25u ng=1
XMUX_L2_A net5 en_VS[2] MASTER_biasout_VN MASTER_biasout_VN sg13_hv_nmos w=0.45u l=11.25u ng=1
XMUX_L2_B net6 en_VSB[2] MASTER_biasout_VN MASTER_biasout_VN sg13_hv_nmos w=0.45u l=11.25u ng=1
V_ref_u_0 MASTER_bias_VN[0] net7 0
V_ref_u_1 MASTER_bias_VN[1] net8 0
V_ref_u_2 MASTER_bias_VN[2] net9 0
V_ref_u_3 MASTER_bias_VN[3] net10 0
V_ref_u_4 MASTER_bias_VN[4] net11 0
V_ref_u_5 MASTER_bias_VN[5] net12 0
V_ref_u_6 MASTER_bias_VN[6] net13 0
V_ref_u_7 MASTER_bias_VN[7] net14 0
.ends

.GLOBAL GND
.end
