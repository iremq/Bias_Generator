** sch_path: /foss/designs/ihp_INI_project/xschem_bias_gen/test_bench/SelMUX_dc_tb.sch
**.subckt SelMUX_dc_tb
v_en BIASGEN_en_VS vssa 1.2
Vdd vdda vssa 1.2
Vss vssa GND 0
xinv[2] vdda en_VSB[2] en_VS[2] vssa inv
xinv[1] vdda en_VSB[1] en_VS[1] vssa inv
xinv[0] vdda en_VSB[0] en_VS[0] vssa inv
V0 en_VS[0] vssa 1.2
V1 en_VS[1] vssa 1.2
V2 en_VS[2] vssa 1.2
x1 ref_VUN[7] ref_VUN[6] ref_VUN[5] ref_VUN[4] ref_VUN[3] ref_VUN[2] ref_VUN[1] ref_VUN[0] vssa en_VS[2] en_VS[1] en_VS[0]
+ en_VSB[2] en_VSB[1] en_VSB[0] net2 SelMUX
x2 net2 vssa BIASGEN_en_VS net1 ISINK
x3 ref_VUN[7] ref_VUN[6] ref_VUN[5] ref_VUN[4] ref_VUN[3] ref_VUN[2] ref_VUN[1] ref_VUN[0] vssa BIASGEN_en_VS CoreDiodeT
I0 vdda ref_VUN[0] 100f
I1 vdda ref_VUN[1] 1p
I2 vdda ref_VUN[2] 10p
I3 vdda ref_VUN[3] 100p
I4 vdda ref_VUN[4] 1n
I6 vdda ref_VUN[6] 100n
I5 vdda ref_VUN[5] 10n
I7 vdda ref_VUN[7] 1u
V_BIAS_UN vdda net1 0
**** begin user architecture code

.lib cornerMOShv.lib mos_tt

.param temp=27

.options abstol=1e-15
.options gmin=1e-15
.control
save all
let digitalCommand = vector(8)
let BIAS_UN = vector(8)

let code = 0

while code < 8
    * Set the 8 bits
    alter V0 = 1.2*(code % 2)
    alter V1 = 1.2*(floor(code/2) % 2)
    alter V2 = 1.2*(floor(code/4) % 2)
    op
    let digitalCommand[code] = code
    let BIAS_UN[code] = I(V_bias_UN)
    let code = code + 1
    write SelMux_cases/SelMux_case_{$&code}.raw
end

    setplot const
    settype current BIAS_UN
    setscale digitalCommand
    plot BIAS_UN

    write SelMUC_dc_tb.raw BIAS_UN

.endc

**** end user architecture code
**.ends

* expanding   symbol:  inv.sym # of pins=4
** sym_path: /foss/designs/ihp_INI_project/xschem_bias_gen/inv.sym
** sch_path: /foss/designs/ihp_INI_project/xschem_bias_gen/inv.sch
.subckt inv vdda out in vssa
*.ipin in
*.opin out
*.iopin vssa
*.iopin vdda
XM1 out in vdda vdda sg13_hv_pmos w=4u l=0.5u ng=1
XM2 out in vssa vssa sg13_hv_nmos w=4u l=0.5u ng=1
.ends

* expanding   symbol:  SelMUX.sym # of pins=5
** sym_path: /foss/designs/ihp_INI_project/xschem_bias_gen/SelMUX.sym
** sch_path: /foss/designs/ihp_INI_project/xschem_bias_gen/SelMUX.sch
.subckt SelMUX MASTER_bias_VN[7] MASTER_bias_VN[6] MASTER_bias_VN[5] MASTER_bias_VN[4] MASTER_bias_VN[3] MASTER_bias_VN[2]
+ MASTER_bias_VN[1] MASTER_bias_VN[0] vssa en_VS[2] en_VS[1] en_VS[0] en_VSB[2] en_VSB[1] en_VSB[0] MASTER_biasout_VN
*.ipin
*+ MASTER_bias_VN[7],MASTER_bias_VN[6],MASTER_bias_VN[5],MASTER_bias_VN[4],MASTER_bias_VN[3],MASTER_bias_VN[2],MASTER_bias_VN[1],MASTER_bias_VN[0]
*.opin MASTER_biasout_VN
*.ipin en_VS[2],en_VS[1],en_VS[0]
*.ipin en_VSB[2],en_VSB[1],en_VSB[0]
*.iopin vssa
XMUX_L0_0 net14 en_VS[0] net1 vssa sg13_hv_nmos w=5u l=0.45u ng=1
XMUX_L0_1 net13 en_VSB[0] net1 vssa sg13_hv_nmos w=0.45u l=10u ng=1
XMUX_L0_2 net12 en_VS[0] net2 vssa sg13_hv_nmos w=0.45u l=10u ng=1
XMUX_L0_3 net11 en_VSB[0] net2 vssa sg13_hv_nmos w=0.45u l=10u ng=1
XMUX_L0_4 net10 en_VS[0] net3 vssa sg13_hv_nmos w=0.45u l=10u ng=1
XMUX_L0_5 net9 en_VSB[0] net3 vssa sg13_hv_nmos w=0.45u l=10u ng=1
XMUX_L0_6 net8 en_VS[0] net4 vssa sg13_hv_nmos w=0.45u l=10u ng=1
XMUX_L0_7 net7 en_VSB[0] net4 vssa sg13_hv_nmos w=0.45u l=10u ng=1
XMUX_L1_A net1 en_VS[1] net5 vssa sg13_hv_nmos w=5u l=0.45u ng=1
XMUX_L1_B net2 en_VSB[1] net5 vssa sg13_hv_nmos w=0.45u l=10u ng=1
XMUX_L1_C net3 en_VS[1] net6 vssa sg13_hv_nmos w=0.45u l=10u ng=1
XMUX_L1_D net4 en_VSB[1] net6 vssa sg13_hv_nmos w=0.45u l=10u ng=1
XMUX_L2_A net5 en_VS[2] MASTER_biasout_VN vssa sg13_hv_nmos w=5u l=0.45u ng=1
XMUX_L2_B net6 en_VSB[2] MASTER_biasout_VN vssa sg13_hv_nmos w=0.45u l=10u ng=1
V_ref_u_0 MASTER_bias_VN[0] net7 0
V_ref_u_1 MASTER_bias_VN[1] net8 0
V_ref_u_2 MASTER_bias_VN[2] net9 0
V_ref_u_3 MASTER_bias_VN[3] net10 0
V_ref_u_4 MASTER_bias_VN[4] net11 0
V_ref_u_5 MASTER_bias_VN[5] net12 0
V_ref_u_6 MASTER_bias_VN[6] net13 0
V_ref_u_7 MASTER_bias_VN[7] net14 0
.ends

* expanding   symbol:  ISINK.sym # of pins=4
** sym_path: /foss/designs/ihp_INI_project/xschem_bias_gen/ISINK.sym
** sch_path: /foss/designs/ihp_INI_project/xschem_bias_gen/ISINK.sch
.subckt ISINK bias_VN vssa en_VS io_UN
*.ipin en_VS
*.iopin vssa
*.ipin bias_VN
*.iopin io_UN
XM1 io_UN en_VS net2 vssa sg13_hv_nmos w=2.5u l=0.5u ng=1
XM2 net2 bias_VN net1 vssa sg13_hv_nmos w=1u l=2u ng=1
XM3 net1 bias_VN vssa vssa sg13_hv_nmos w=1u l=2u ng=1
.ends

* expanding   symbol:  CoreDiodeT.sym # of pins=3
** sym_path: /foss/designs/ihp_INI_project/xschem_bias_gen/CoreDiodeT.sym
** sch_path: /foss/designs/ihp_INI_project/xschem_bias_gen/CoreDiodeT.sch
.subckt CoreDiodeT ref_VUN[7] ref_VUN[6] ref_VUN[5] ref_VUN[4] ref_VUN[3] ref_VUN[2] ref_VUN[1] ref_VUN[0] vssa en_VS
*.iopin ref_VUN[7],ref_VUN[6],ref_VUN[5],ref_VUN[4],ref_VUN[3],ref_VUN[2],ref_VUN[1],ref_VUN[0]
*.ipin en_VS
*.iopin vssa
x1 net8 vssa en_VS net8 ISINK
x2 net7 vssa en_VS net7 ISINK
x3 net1 vssa en_VS net1 ISINK
x4 net2 vssa en_VS net2 ISINK
x5 net3 vssa en_VS net3 ISINK
x6 net4 vssa en_VS net4 ISINK
x7 net5 vssa en_VS net5 ISINK
x8 net6 vssa en_VS net6 ISINK
C0 net6 vssa 2p
C1 net5 vssa 2p
C2 net4 vssa 2p
C3 net3 vssa 2p
C4 net2 vssa 2p
C5 net1 vssa 2p
C6 net7 vssa 2p
C7 net8 vssa 2p
V_ref_u_0 ref_VUN[0] net6 0
V_ref_u_1 ref_VUN[1] net5 0
V_ref_u_2 ref_VUN[2] net4 0
V_ref_u_3 ref_VUN[3] net3 0
V_ref_u_4 ref_VUN[4] net2 0
V_ref_u_5 ref_VUN[5] net1 0
V_ref_u_6 ref_VUN[6] net7 0
V_ref_u_7 ref_VUN[7] net8 0
.ends

.GLOBAL GND
.end
