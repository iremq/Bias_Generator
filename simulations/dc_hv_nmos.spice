** sch_path: /foss/pdks/ihp-sg13g2/libs.tech/xschem/sg13g2_tests/dc_hv_nmos.sch
**.subckt dc_hv_nmos
Vgs net1 GND 0.75
Vds net2 GND 1.2
Vd net2 net3 0
.save i(vd)
XM_s1 net3 net1 net4 GND sg13_hv_nmos w=14.4u l=0.45u ng=2
XM_s2 net4 net1 net5 GND sg13_hv_nmos w=14.4u l=0.45u ng=2
XM_s3 net5 net1 net6 GND sg13_hv_nmos w=14.4u l=0.45u ng=2
XM_s4 net6 net1 GND GND sg13_hv_nmos w=14.4u l=0.45u ng=2
**** begin user architecture code

.lib cornerMOShv.lib mos_tt

.options savecurrents
.include dc_hv_nmos.save
.param temp=27
.control
save all
op
write dc_hv_nmos.raw
set appendwrite
dc Vgs 0 1.2 0.05
write dc_hv_nmos.raw
.endc

**** end user architecture code
**.ends
.GLOBAL GND
.end
