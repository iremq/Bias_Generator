** sch_path: /foss/designs/ihp_INI_project/xschem_bias_gen/test_bench/SplitterCell_dc_tb.sch
**.subckt SplitterCell_dc_tb
x1 en_VS vssa net2 en_VSB bias_VPN vssa net1 net4 SplitterCell
v_bias_VPN bias_VPN Vssa 1.2
Vdd vdda vssa 1.2
v_en_VS en_VS Vssa 1.2
Vss vssa GND 0
XM_enb vdda vdda net3 vssa sg13_hv_nmos w=7.2u l=0.45u ng=1
XM_s9 net2 bias_VPN net5 vssa sg13_hv_nmos w=14.4u l=0.45u ng=2
XM_s10 net5 bias_VPN net6 vssa sg13_hv_nmos w=14.4u l=0.45u ng=2
XM_s11 net6 bias_VPN net7 vssa sg13_hv_nmos w=14.4u l=0.45u ng=2
XM_s12 net7 bias_VPN net3 vssa sg13_hv_nmos w=14.4u l=0.45u ng=2
x2 vdda en_VSB en_VS vssa inv
V_out_UPB vdda net1 0
.save i(v_out_upb)
V_out_UP vdda net4 0
.save i(v_out_up)
**** begin user architecture code

.lib cornerMOShv.lib mos_tt

.param temp=27

.control

save all V(en_VS) V(en_VSB) I(v_out_UP) I(v_out_UPB) I(v_isplit) V(bias_VPN)
dc V_bias_VPN 0 1.2 0.001 V_en_VS 0 1.2 1.2
write SplitterCell_dc_tb.raw

.endc

**** end user architecture code
**.ends

* expanding   symbol:  SplitterCell.sym # of pins=9
** sym_path: /foss/designs/ihp_INI_project/xschem_bias_gen/SplitterCell.sym
** sch_path: /foss/designs/ihp_INI_project/xschem_bias_gen/SplitterCell.sch
.subckt SplitterCell en_VS A_UN B_UN en_VSB bias_VN vssa out_UPB out_UP
*.ipin en_VS
*.ipin en_VSB
*.ipin bias_VN
*.iopin B_UN
*.iopin out_UP
*.iopin out_UPB
*.iopin vssa
*.iopin A_UN
XM_en out_UP en_VS net1 vssa sg13_hv_nmos w=7.2u l=0.45u ng=1
XM_enb out_UPB en_VSB net1 vssa sg13_hv_nmos w=7.2u l=0.45u ng=1
XM_s1 net1 bias_VN net3 vssa sg13_hv_nmos w=14.4u l=0.45u ng=2
XM_s2 net3 bias_VN net4 vssa sg13_hv_nmos w=14.4u l=0.45u ng=2
XM_s3 net4 bias_VN net5 vssa sg13_hv_nmos w=14.4u l=0.45u ng=2
XM_s4 net5 bias_VN net2 vssa sg13_hv_nmos w=14.4u l=0.45u ng=2
XM_s5 net2 bias_VN net6 vssa sg13_hv_nmos w=14.4u l=0.45u ng=2
XM_s6 net6 bias_VN net7 vssa sg13_hv_nmos w=14.4u l=0.45u ng=2
XM_s7 net7 bias_VN net8 vssa sg13_hv_nmos w=14.4u l=0.45u ng=2
XM_s8 net8 bias_VN A_UN vssa sg13_hv_nmos w=14.4u l=0.45u ng=2
XM_s9 A_UN bias_VN net9 vssa sg13_hv_nmos w=14.4u l=0.45u ng=2
XM_s10 net9 bias_VN net10 vssa sg13_hv_nmos w=14.4u l=0.45u ng=2
XM_s11 net10 bias_VN net11 vssa sg13_hv_nmos w=14.4u l=0.45u ng=2
XM_s12 net11 bias_VN B_UN vssa sg13_hv_nmos w=14.4u l=0.45u ng=2
.ends

* expanding   symbol:  inv.sym # of pins=4
** sym_path: /foss/designs/ihp_INI_project/xschem_bias_gen/inv.sym
** sch_path: /foss/designs/ihp_INI_project/xschem_bias_gen/inv.sch
.subckt inv vdda out in vssa
*.ipin in
*.opin out
*.iopin vssa
*.iopin vdda
XM1 out in vdda vdda sg13_hv_pmos w=4u l=0.5u ng=1
XM2 out in vssa vssa sg13_hv_nmos w=4u l=0.5u ng=1
.ends

.GLOBAL GND
.end
