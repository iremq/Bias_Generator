** sch_path: /foss/designs/ihp_INI_project/xschem_bias_gen/test_bench/SplitterFull_dc_tb.sch
**.subckt SplitterFull_dc_tb
x1 en_VS[3] net5 net1 en_VSB[3] bias_VPN vssa net4 net3 SplitterCell
v_bias_VPN bias_VPN Vssa 0.197
Vdd vdda vssa 1.2
V0 en_VS[3] Vssa 1.2
Vss vssa GND 0
XM_enb vdda vdda net2 vssa sg13_hv_nmos w=7.2u l=0.45u ng=1
XM_s9 net1 bias_VPN net6 vssa sg13_hv_nmos w=14.4u l=0.45u ng=2
XM_s10 net6 bias_VPN net7 vssa sg13_hv_nmos w=14.4u l=0.45u ng=2
XM_s11 net7 bias_VPN net8 vssa sg13_hv_nmos w=14.4u l=0.45u ng=2
XM_s12 net8 bias_VPN net2 vssa sg13_hv_nmos w=14.4u l=0.45u ng=2
xinv[10] vdda en_VSB[10] en_VS[10] vssa inv
xinv[9] vdda en_VSB[9] en_VS[9] vssa inv
xinv[8] vdda en_VSB[8] en_VS[8] vssa inv
xinv[7] vdda en_VSB[7] en_VS[7] vssa inv
xinv[6] vdda en_VSB[6] en_VS[6] vssa inv
xinv[5] vdda en_VSB[5] en_VS[5] vssa inv
xinv[4] vdda en_VSB[4] en_VS[4] vssa inv
xinv[3] vdda en_VSB[3] en_VS[3] vssa inv
V_out_UPB vdda net4 0
.save i(v_out_upb)
V_out_UP vdda net3 0
.save i(v_out_up)
x3 en_VS[4] net9 net5 en_VSB[4] bias_VPN vssa net4 net3 SplitterCell
x4 en_VS[5] net10 net9 en_VSB[5] bias_VPN vssa net4 net3 SplitterCell
x5 en_VS[6] net11 net10 en_VSB[6] bias_VPN vssa net4 net3 SplitterCell
x6 en_VS[7] net12 net11 en_VSB[7] bias_VPN vssa net4 net3 SplitterCell
x7 en_VS[8] net13 net12 en_VSB[8] bias_VPN vssa net4 net3 SplitterCell
x8 en_VS[9] net14 net13 en_VSB[9] bias_VPN vssa net4 net3 SplitterCell
x9 en_VS[10] vssa net14 en_VSB[10] bias_VPN vssa net4 net3 SplitterCell
V1 en_VS[4] Vssa 1.2
V2 en_VS[5] Vssa 1.2
V3 en_VS[6] Vssa 1.2
V4 en_VS[7] Vssa 1.2
V5 en_VS[8] Vssa 1.2
V6 en_VS[9] Vssa 1.2
V7 en_VS[10] Vssa 1.2
**** begin user architecture code

.lib cornerMOShv.lib mos_tt

.param temp=27

.options abstol=1e-16
.options gmin=1e-16
.control

let digitalCommand = vector(256)
let out_UP   = vector(256)

let code = 0

while code < 256

    * Set the 8 bits
    alter V0 = 1.2*(code % 2)
    alter V1 = 1.2*(floor(code/2) % 2)
    alter V2 = 1.2*(floor(code/4) % 2)
    alter V3 = 1.2*(floor(code/8) % 2)
    alter V4 = 1.2*(floor(code/16) % 2)
    alter V5 = 1.2*(floor(code/32) % 2)
    alter V6 = 1.2*(floor(code/64) % 2)
    alter V7 = 1.2*(floor(code/128) % 2)

    op

    let digitalCommand[code] = code
    let out_UP[code]   = 0
    let out_UP[code]   = I(V_out_UP)
    let code = code + 1
end

    setplot const
    settype current out_UP
    setscale digitalCommand
    plot out_UP
    write SpllitterFull_10p_dc_tb.raw out_UP

.endc

**** end user architecture code
**.ends

* expanding   symbol:  SplitterCell.sym # of pins=9
** sym_path: /foss/designs/ihp_INI_project/xschem_bias_gen/SplitterCell.sym
** sch_path: /foss/designs/ihp_INI_project/xschem_bias_gen/SplitterCell.sch
.subckt SplitterCell en_VS A_UN B_UN en_VSB bias_VN vssa out_UPB out_UP
*.ipin en_VS
*.ipin en_VSB
*.ipin bias_VN
*.iopin B_UN
*.iopin out_UP
*.iopin out_UPB
*.iopin vssa
*.iopin A_UN
XM_en out_UP en_VS net1 vssa sg13_hv_nmos w=7.2u l=0.45u ng=1
XM_enb out_UPB en_VSB net1 vssa sg13_hv_nmos w=7.2u l=0.45u ng=1
XM_s1 net1 bias_VN net3 vssa sg13_hv_nmos w=14.4u l=0.45u ng=2
XM_s2 net3 bias_VN net4 vssa sg13_hv_nmos w=14.4u l=0.45u ng=2
XM_s3 net4 bias_VN net5 vssa sg13_hv_nmos w=14.4u l=0.45u ng=2
XM_s4 net5 bias_VN net2 vssa sg13_hv_nmos w=14.4u l=0.45u ng=2
XM_s5 net2 bias_VN net6 vssa sg13_hv_nmos w=14.4u l=0.45u ng=2
XM_s6 net6 bias_VN net7 vssa sg13_hv_nmos w=14.4u l=0.45u ng=2
XM_s7 net7 bias_VN net8 vssa sg13_hv_nmos w=14.4u l=0.45u ng=2
XM_s8 net8 bias_VN A_UN vssa sg13_hv_nmos w=14.4u l=0.45u ng=2
XM_s9 A_UN bias_VN net9 vssa sg13_hv_nmos w=14.4u l=0.45u ng=2
XM_s10 net9 bias_VN net10 vssa sg13_hv_nmos w=14.4u l=0.45u ng=2
XM_s11 net10 bias_VN net11 vssa sg13_hv_nmos w=14.4u l=0.45u ng=2
XM_s12 net11 bias_VN B_UN vssa sg13_hv_nmos w=14.4u l=0.45u ng=2
.ends

* expanding   symbol:  inv.sym # of pins=4
** sym_path: /foss/designs/ihp_INI_project/xschem_bias_gen/inv.sym
** sch_path: /foss/designs/ihp_INI_project/xschem_bias_gen/inv.sch
.subckt inv vdda out in vssa
*.ipin in
*.opin out
*.iopin vssa
*.iopin vdda
XM1 out in vdda vdda sg13_hv_pmos w=4u l=0.5u ng=1
XM2 out in vssa vssa sg13_hv_nmos w=4u l=0.5u ng=1
.ends

.GLOBAL GND
.end
